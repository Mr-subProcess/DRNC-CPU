* RAQM-02G single-cell analog core — SPICE candidate
* NOT A RELEASED DESIGN. Proxy model only; see models/DI_BC847BS_PROXY.lib.
.include "models/DI_BC847BS_PROXY.lib"

* Rails and externally set bias references
VDD VDD_CML 0 DC 5.0
VBIAS VBIAS_SRC 0 DC 1.00
VCMD VCM_DATA 0 DC 4.16
VCMW VCM_WE 0 DC 3.45
VREF VREF_FB 0 DC 3.50

* Matched-pair package U1 = U_DATA
* pin 1 E1, pin 2 B1, pin 3 C2, pin 4 E2, pin 5 B2, pin 6 C1
XU1 E_DATA D_P OUT_N E_DATA D_N OUT_P BCM847BS_PROXY

* Matched-pair package U2 = U_FB; intentionally cross-coupled:
* TR1 collector OUT_P is controlled by FB_N (from OUT_N divider),
* TR2 collector OUT_N is controlled by FB_P (from OUT_P divider).
XU2 E_FB FB_N OUT_N E_FB FB_P OUT_P BCM847BS_PROXY

* Matched-pair package U3 = U_SEL; steers tail current to DATA or feedback pair
XU3 TAIL_NODE WE_P E_FB TAIL_NODE WE_N E_DATA BCM847BS_PROXY

* Tail sink (BC847B single NPN represented by same generic proxy model)
QTAIL TAIL_NODE BIAS_Q TAIL_EMIT DI_BC847BS
R_BIAS_TAIL VBIAS_SRC BIAS_Q 1k
R_TAIL TAIL_EMIT SENSE_P 470
R_SENSE SENSE_P 0 10

* Collector loads
R_LOAD_P VDD_CML OUT_P 470
R_LOAD_N VDD_CML OUT_N 470

* Cross-coupled feedback divider network
R_FB_PT OUT_P FB_P 22k
R_FB_PB FB_P VREF_FB 22k
R_FB_NT OUT_N FB_N 22k
R_FB_NB FB_N VREF_FB 22k

* Weak common-mode bias and differential termination
R_DATA_BIAS_P VCM_DATA D_P 10k
R_DATA_BIAS_N VCM_DATA D_N 10k
R_DATA_TERM D_P D_N 100
R_WE_BIAS_P VCM_WE WE_P 10k
R_WE_BIAS_N VCM_WE WE_N 10k
R_WE_TERM WE_P WE_N 100

* Local bypass candidates (ideal sources are shown; real source impedance matters)
C_VCM_DATA VCM_DATA 0 100n
C_VCM_WE VCM_WE 0 100n
C_VREF VREF_FB 0 100n
C_VDD VDD_CML 0 4.7u

* Parasitic/measurement load placeholders; not a PCB extraction
C_OUT_P OUT_P 0 0.5p
C_OUT_N OUT_N 0 0.5p
C_E_DATA E_DATA 0 0.5p
C_E_FB E_FB 0 0.5p

* Differential input sources are open-circuit values. With 50 ohm each leg
* and 100 ohm differential termination, the base differential is approximately
* half the source differential. Confirm at the transistor bases in a real test.
V_DPS D_P_SRC 0 PWL(0 4.26 0.99u 4.26 1.00u 4.06 1.99u 4.06 2.00u 4.26 3.00u 4.26)
R_DPS D_P_SRC D_P 50
V_DNS D_N_SRC 0 PWL(0 4.06 0.99u 4.06 1.00u 4.26 1.99u 4.26 2.00u 4.06 3.00u 4.06)
R_DNS D_N_SRC D_N 50

* WRITE selected 0..0.5 us; HOLD 0.5..1.5 us; reverse DATA then WRITE
* 1.5..2.0 us; HOLD 2.0..3.0 us. Four-phase handshake is external/not simulated.
V_WPS WE_P_SRC 0 PWL(0 3.55 0.50u 3.55 0.501u 3.35 1.499u 3.35 1.50u 3.55 2.00u 3.55 2.001u 3.35 3.00u 3.35)
R_WPS WE_P_SRC WE_P 50
V_WNS WE_N_SRC 0 PWL(0 3.35 0.50u 3.35 0.501u 3.55 1.499u 3.55 1.50u 3.35 2.00u 3.35 2.001u 3.55 3.00u 3.55)
R_WNS WE_N_SRC WE_N 50

.nodeset V(OUT_P)=4.75 V(OUT_N)=4.95
.options reltol=1e-4 abstol=1e-12 vntol=1e-7 gmin=1e-12 method=gear maxord=2
.control
set noaskquit
tran 0.5n 3u 0 0.5n
let vdiff = v(OUT_N)-v(OUT_P)
let itail = v(SENSE_P)/10
wrdata RAQM02G_WRITE_HOLD_TRAN.csv v(OUT_P) v(OUT_N) vdiff v(E_DATA) v(E_FB) v(TAIL_NODE) itail v(WE_P) v(WE_N) v(D_P) v(D_N)
write RAQM02G_WRITE_HOLD_TRAN.raw all
.endc
.end
